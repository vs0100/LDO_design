ADE simulation setup
Run mode: Single Run, Sweeps and Corners
Tests:
  Trapper:n_tp_vds0.4:1: Trapper/n_tp_vds0.4/schematic, simulator spectre
Global variables:
  l_nmos = 45n
  vd = 0.4
  Vg = 0
  w_nmos = 1u
