ADE simulation setup
Run mode: Single Run, Sweeps and Corners
Tests:
  Trapper:p_tp_vd0.4:1: Trapper/p_tp_vd0.4/schematic, simulator spectre
Global variables:
  l_pmos = 45n
  vd = 0.4
  vg = 0
  w_pmos = 1u
